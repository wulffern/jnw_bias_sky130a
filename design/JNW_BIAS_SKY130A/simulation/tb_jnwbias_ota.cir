.param mc_mm_switch=0
.param mc_pr_switch=0

.include tt.spi
*.include ss.spi

.lib "../../../tech/ngspice/temperature.spi" Tl

.lib "../../../tech/ngspice/supply.spi" Vl

.include ../../../../cpdk/ngspice/ideal_circuits.spi

.option savecurrents
.save all
.control
optran 0 0 0 10n 10u 0
op

ac dec 50 1 1e9

let vo_mag = db(v(vo))

write TB_JNWBIAS_OTA.raw
exit
.endc
.end
